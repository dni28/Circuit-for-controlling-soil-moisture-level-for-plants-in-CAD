** Profile: "SCHEMATIC1-DC_Sweep1"  [ C:\Users\salaj\Desktop\Proiect_CAD\project_cad-pspicefiles\schematic1\dc_sweep1.sim ]

** Creating circuit file "DC_Sweep1.cir"
** WARNING: THIS AUTOMATICALLY GENERATED FILE MAY BE OVERWRITTEN BY SUBSEQUENT SIMULATIONS

*Libraries:
* Profile Libraries :
* Local Libraries :
* From [PSPICE NETLIST] section of D:\Cadence_Orcad\cdssetup\OrCAD_PSpice\24.1.0\PSpice.ini file:
.lib "nom.lib"

*Analysis directives:
.DC LIN PARAM rvar 60k 600k 1k
.OPTIONS ADVCONV
.PROBE64 V(alias(*)) I(alias(*)) W(alias(*)) D(alias(*)) NOISE(alias(*))
.INC "..\SCHEMATIC1.net"

.END
